; cadence_runtime.il — the SKILL-only twin of cadence_runtime.py (drawio,
; exporters/cadence). The generated .il holds cadxPlan (the neutral schematic
; in Virtuoso user units, y up), cadxDefaultMap (analogLib) and this file.
; Usage in the CIW:  load("x.il")  cadxExport("WORKLIB")
;                    cadxExport("WORKLIB" ?cell "c" ?map "my.map" ?overwrite t)
; It reads the real pins in the masters, places each instance in the best of
; the 8 orientations, joins pins to planned points, draws wires, labels,
; ground symbols and pins, runs schCheck, compares the connectivity with the
; SOURCE deck, and writes a report of COUNTS only (no library, cell,
; parameter or path name). Nothing is sent anywhere.

cadxEps = 1e-6
cadxVersion = "0.1"

procedure(cadxD(kv) let((tb) tb = makeTable("cadxD" nil) while(kv tb[car(kv)] = cadr(kv) kv = cdr(cdr(kv))) tb))

; (negatives go through variables: in SKILL `list(x -y)` reads as x - y)
procedure(cadxXf(p o) let((x y mx my) x = car(p) y = cadr(p) mx = -x my = -y
  cond(
    (o == "R0" list(x y)) (o == "R90" list(my x)) (o == "R180" list(mx my)) (o == "R270" list(y mx))
    (o == "MY" list(mx y)) (o == "MX" list(x my)) (o == "MYR90" list(my mx)) (t list(y x)))))

procedure(cadxSame(a b) abs(car(a) - car(b)) < cadxEps && abs(cadr(a) - cadr(b)) < cadxEps)

procedure(cadxCentre(bb) list((car(car(bb)) + car(cadr(bb))) / 2.0 (cadr(car(bb)) + cadr(cadr(bb))) / 2.0))

procedure(cadxSnap(v g) round(v / g) * g)

procedure(cadxOnSeg(p a b)
  !(car(p) < min(car(a) car(b)) - cadxEps || car(p) > max(car(a) car(b)) + cadxEps
    || cadr(p) < min(cadr(a) cadr(b)) - cadxEps || cadr(p) > max(cadr(a) cadr(b)) + cadxEps)
  && abs((car(b) - car(a)) * (cadr(p) - cadr(a)) - (cadr(b) - cadr(a)) * (car(p) - car(a))) < cadxEps)

; ---------------------------------------------------------------- the map

procedure(cadxTrim(s) let((w) w = parseString(s " \t\n")
  if(w then let((r) r = car(w) foreach(x cdr(w) r = strcat(r " " x)) r) else "")))

procedure(cadxMapLine(m raw) let((line i k)
  line = raw
  i = nindex(line "#")
  when(i line = if(i > 1 then substring(line 1 i - 1) else ""))
  i = nindex(line "=")
  when(i && i > 1
    k = cadxTrim(substring(line 1 i - 1))
    when(strlen(k) > 0
      m[k] = if(i < strlen(line) then cadxTrim(substring(line i + 1)) else "")
      unless(member(k m["@keys"]) m["@keys"] = cons(k m["@keys"]))))
  m))

procedure(cadxParseMap(text m) let((start i n)
  start = 1 n = strlen(text)
  while(start <= n
    i = nindex(substring(text start) "\n")
    if(i then cadxMapLine(m substring(text start i - 1)) start = start + i
    else cadxMapLine(m substring(text start)) start = n + 1))
  m))

procedure(cadxReadMap(path m) let((port line)
  port = infile(path)
  unless(port error("map file not readable"))
  while(gets(line port) cadxMapLine(m line))
  close(port)
  m))

procedure(cadxEntry(m comp) let((key lib cell params pre n)
  key = m[strcat("model." lowerCase(if(comp["model"] then comp["model"] else "")))]
  unless(key key = comp["role"])
  lib = m[strcat(key ".lib")] cell = m[strcat(key ".cell")]
  when(lib && cell
    pre = strcat(key ".param.") n = strlen(pre)
    foreach(k m["@keys"]
      when(strlen(k) > n && substring(k 1 n) == pre params = cons(list(substring(k n + 1) m[k]) params)))
    cadxD(list("lib" lib "cell" cell "view" if(m[strcat(key ".view")] then m[strcat(key ".view")] else "symbol")
               "terms" parseString(if(m[strcat(key ".terms")] then m[strcat(key ".terms")] else "")) "params" params)))))

procedure(cadxParam(comp source) let((p)
  p = comp["params"]
  cond(
    (!p nil)
    (source == "model" || source == "value" || source == "dc" p[source])
    (p["kv"] p["kv"][lowerCase(source)])
    (t nil))))

; ---------------------------------------------------------------- export state

procedure(cadxNew(plan m lib cell overwrite)
  cadxD(list("plan" plan "m" m "lib" lib "cell" cell "overwrite" overwrite "g" plan["grid"]
             "masters" makeTable("masters" nil) "profile" makeTable("profile" nil) "insts" makeTable("insts" nil) "refs" nil
             "taken" nil "segs" nil "needLabel" nil "problems" nil "local" nil
             "stubs" 0 "stubLength" 0.0 "fallbacks" 0 "bulkLabels" 0 "paramsSet" 0 "paramsSkipped" 0
             "segments" 0 "labels" 0)))

procedure(cadxProblem(S msg) unless(member(msg S["problems"]) S["problems"] = cons(msg S["problems"])))

procedure(cadxMaster(S lib cell view) let((k)
  k = strcat(lib "/" cell "/" view)
  unless(S["masters"][k] S["masters"][k] = dbOpenCellViewByType(lib cell view nil "r"))
  S["masters"][k]))

procedure(cadxOffsets(mst) let((out)
  out = makeTable("offs" nil)
  foreach(tm mst->terminals when(tm->pins out[tm->name] = cadxCentre(car(tm->pins)->fig->bBox)))
  out))

procedure(cadxTake(S a b net) S["taken"] = cons(list(a b net) S["taken"]))

procedure(cadxWire(S pts net) let((clean prev segs)
  foreach(p pts unless(prev && cadxSame(p prev) clean = append1(clean p)) prev = p)
  when(length(clean) >= 2
    segs = schCreateWire(S["cv"] "draw" "full" clean S["g"] S["g"] 0.0)
    S["segments"] = S["segments"] + length(segs)
    prev = nil
    foreach(p clean when(prev cadxTake(S prev p net)) prev = p))
  segs))

procedure(cadxLabel(S seg at text)
  schCreateWireLabel(S["cv"] seg at text "lowerCenter" "R0" "stick" S["g"] nil)
  S["labels"] = S["labels"] + 1)

procedure(cadxFree(S path net) let((ok prev)
  ok = t
  foreach(b path
    when(prev && ok
      foreach(x S["taken"]
        when(ok && caddr(x) != net
          when(cadxOnSeg(car(x) prev b) || cadxOnSeg(cadr(x) prev b) || cadxOnSeg(prev car(x) cadr(x)) || cadxOnSeg(b car(x) cadr(x))
            ok = nil))))
    prev = b)
  ok))

procedure(cadxOpposite(d) let((a b) a = -car(d) b = -cadr(d) list(a b)))

procedure(cadxStubOut(S inst at net text) let((bb c dx dy d1 d2 dirs done end segs g)
  g = S["g"]
  bb = dbTransformBBox(inst->master->bBox inst->transform)
  c = cadxCentre(bb)
  dx = car(at) - car(c) dy = cadr(at) - cadr(c)
  d1 = list(if(dx >= 0 then 1 else -1) 0) d2 = list(0 if(dy >= 0 then 1 else -1))
  dirs = if(abs(dx) >= abs(dy) then list(d1 d2) else list(d2 d1))
  dirs = append(dirs list(cadxOpposite(car(dirs)) cadxOpposite(cadr(dirs))))
  foreach(d dirs foreach(n list(2 3 4 6)
    unless(done
      end = list(cadxSnap(car(at) + car(d) * n * g g) cadxSnap(cadr(at) + cadr(d) * n * g g))
      when(cadxFree(S list(at end) net)
        segs = cadxWire(S list(at end) net)
        when(segs cadxLabel(S car(cadxLast(segs)) end text) done = t)))))
  unless(done cadxProblem(S "no free place for a label stub"))
  done))

procedure(cadxLast(l) let((r) while(l r = l l = cdr(l)) r))

; ---------------------------------------------------------------- steps

procedure(cadxOpen(S) let((old)
  unless(ddGetObj(S["lib"]) error("work library not found"))
  old = dbOpenCellViewByType(S["lib"] S["cell"] "schematic" nil "r")
  when(old && !S["overwrite"] error("the schematic already exists: choose another ?cell or ?overwrite t"))
  S["cv"] = dbOpenCellViewByType(S["lib"] S["cell"] "schematic" "schematic" "w")
  unless(S["cv"] error("could not open the schematic for writing"))))

procedure(cadxPlace(S) let((e mst offs need ok drawn best ts ox oy cost inst v actual pts nets k g)
  g = S["g"]
  foreach(comp S["plan"]["components"]
    e = cadxEntry(S["m"] comp)
    mst = nil
    if(!e then cadxProblem(S strcat("no symbol in the map for role " comp["role"]))
    else
      mst = cadxMaster(S e["lib"] e["cell"] e["view"])
      unless(mst cadxProblem(S strcat("symbol not found for role " comp["role"]))))
    when(mst
      offs = cadxOffsets(mst)
      unless(S["profile"][comp["role"]] S["profile"][comp["role"]] = list(e["terms"] mst->bBox offs))
      need = nil
      foreach(p comp["pins"] need = append1(need p["index"]))
      foreach(h comp["hidden"] need = append1(need h["index"]))
      ok = t
      foreach(i need when(i >= length(e["terms"]) || !offs[nth(i e["terms"])] ok = nil))
      if(!ok then cadxProblem(S strcat("symbol terminals do not match the map for role " comp["role"]))
      else
        drawn = nil
        foreach(p comp["pins"] drawn = append1(drawn list(nth(p["index"] e["terms"]) p["at"])))
        best = nil
        foreach(o list("R0" "R90" "R180" "R270" "MY" "MYR90" "MX" "MXR90")
          if(drawn then
            ts = nil
            foreach(d drawn ts = append1(ts cadxXf(offs[car(d)] o)))
            ox = 0.0 oy = 0.0
            for(j 0 length(drawn) - 1
              ox = ox + car(cadr(nth(j drawn))) - car(nth(j ts))
              oy = oy + cadr(cadr(nth(j drawn))) - cadr(nth(j ts)))
            ox = cadxSnap(ox / length(drawn) g) oy = cadxSnap(oy / length(drawn) g)
            cost = 0.0
            for(j 0 length(drawn) - 1
              cost = cost + (ox + car(nth(j ts)) - car(cadr(nth(j drawn)))) * (ox + car(nth(j ts)) - car(cadr(nth(j drawn))))
                          + (oy + cadr(nth(j ts)) - cadr(cadr(nth(j drawn)))) * (oy + cadr(nth(j ts)) - cadr(cadr(nth(j drawn)))))
          else ox = car(comp["at"]) oy = cadr(comp["at"]) cost = 0.0)
          when(!best || cost < car(best) - 1e-9 best = list(cost o list(ox oy))))
        inst = dbCreateInst(S["cv"] mst comp["ref"] caddr(best) cadr(best))
        if(!inst then cadxProblem(S "an instance could not be created")
        else
          foreach(pp e["params"]
            v = cadxParam(comp cadr(pp))
            if(!v || v == "" then S["paramsSkipped"] = S["paramsSkipped"] + 1
            else dbReplaceProp(inst car(pp) "string" v) S["paramsSet"] = S["paramsSet"] + 1))
          actual = makeTable("actual" nil)
          foreach(tm mst->terminals when(tm->pins actual[tm->name] = cadxCentre(dbTransformBBox(car(tm->pins)->fig->bBox inst->transform))))
          pts = makeTable("pts" nil)
          foreach(i need pts[i] = actual[nth(i e["terms"])])
          S["insts"][comp["ref"]] = list(inst pts e)
          S["refs"] = cons(comp["ref"] S["refs"])
          nets = makeTable("nets" nil)
          foreach(p comp["pins"] nets[p["index"]] = p["net"])
          foreach(h comp["hidden"] nets[h["index"]] = h["net"])
          foreach(i need k = pts[i] cadxTake(S k k nets[i]))))))))

procedure(cadxPlanned(S) let((prev)
  foreach(w S["plan"]["wires"] prev = nil foreach(p w["points"] when(prev cadxTake(S prev p w["net"])) prev = p))
  foreach(comp S["plan"]["components"] foreach(p comp["pins"] cadxTake(S p["at"] p["at"] p["net"])))
  foreach(x append(S["plan"]["ports"] S["plan"]["grounds"]) cadxTake(S x["at"] x["at"] x["net"]))))

procedure(cadxStubs(S) let((got A P done path clean prev len)
  foreach(comp S["plan"]["components"]
    got = S["insts"][comp["ref"]]
    when(got foreach(p comp["pins"]
      A = cadr(got)[p["index"]] P = p["at"]
      unless(cadxSame(A P)
        done = nil
        foreach(cand list(list(A list(car(P) cadr(A)) P) list(A list(car(A) cadr(P)) P))
          unless(done
            clean = nil prev = nil
            foreach(q cand unless(prev && cadxSame(q prev) clean = append1(clean q)) prev = q)
            when(cadxFree(S clean p["net"])
              cadxWire(S clean p["net"])
              S["stubs"] = S["stubs"] + 1
              prev = nil len = 0.0
              foreach(q clean when(prev len = len + abs(car(q) - car(prev)) + abs(cadr(q) - cadr(prev))) prev = q)
              S["stubLength"] = S["stubLength"] + len
              done = t)))
        unless(done
          S["fallbacks"] = S["fallbacks"] + 1
          S["local"] = cons(sprintf(nil "label fallback: %s pin %d" comp["ref"] p["index"]) S["local"])
          cadxStubOut(S car(got) A p["net"] p["label"])
          S["needLabel"] = cons(list(P p["net"] p["label"]) S["needLabel"]))))))))

procedure(cadxLabelAt(S at net text pin) let((done got)
  foreach(x S["segs"] when(!done && cadxOnSeg(at car(x) cadr(x)) cadxLabel(S caddr(x) at text) done = t))
  unless(done
    got = if(pin then S["insts"][pin["ref"]] else nil)
    if(got then cadxStubOut(S car(got) cadr(got)[pin["index"]] net text)
    else cadxProblem(S "a label has no wire to sit on")))))

procedure(cadxDraw(S) let((got)
  S["segs"] = nil
  foreach(w S["plan"]["wires"]
    foreach(s cadxWire(S w["points"] w["net"]) S["segs"] = append1(S["segs"] list(car(s->points) cadr(s->points) s))))
  foreach(lab S["plan"]["labels"] cadxLabelAt(S lab["at"] lab["net"] lab["text"] lab["pin"]))
  foreach(x S["needLabel"] cadxLabelAt(S car(x) cadr(x) caddr(x) nil))
  foreach(comp S["plan"]["components"]
    got = S["insts"][comp["ref"]]
    when(got foreach(h comp["hidden"]
      when(cadxStubOut(S car(got) cadr(got)[h["index"]] h["net"] h["label"]) S["bulkLabels"] = S["bulkLabels"] + 1))))))

procedure(cadxSymbols(S) let((e mst t0 i g)
  g = S["g"]
  when(S["plan"]["grounds"]
    e = cadxEntry(S["m"] cadxD(list("role" "gnd")))
    mst = if(e then cadxMaster(S e["lib"] e["cell"] e["view"]) else nil)
    t0 = if(mst then car(car(cadxTableValues(cadxOffsets(mst)))) else nil)
    if(!t0 then cadxProblem(S "ground symbol not found")
    else i = 0
      foreach(r S["plan"]["grounds"]
        dbCreateInst(S["cv"] mst sprintf(nil "GNDC%d" i) list(cadxSnap(car(r["at"]) - car(t0) g) cadxSnap(cadr(r["at"]) - cadr(t0) g)) "R0")
        i = i + 1)))
  when(S["plan"]["ports"]
    e = cadxEntry(S["m"] cadxD(list("role" "pin")))
    mst = if(e then cadxMaster(S e["lib"] e["cell"] e["view"]) else nil)
    t0 = if(mst then car(car(cadxTableValues(cadxOffsets(mst)))) else nil)
    if(!t0 then cadxProblem(S "pin symbol not found")
    else
      foreach(p S["plan"]["ports"]
        schCreatePin(S["cv"] mst p["name"] if(S["m"]["pin.direction"] then S["m"]["pin.direction"] else "inputOutput") nil
                     list(cadxSnap(car(p["at"]) - car(t0) g) cadxSnap(cadr(p["at"]) - cadr(t0) g)) "R0"))))))

; the values of a table built by cadxOffsets, as list(list(point)), in terminal order of the master
procedure(cadxTableValues(tb) let((out) foreach(k cadxKeys(tb) out = append1(out list(tb[k]))) out))
procedure(cadxKeys(tb) let((ks) foreach(k tb ks = append1(ks k)) ks))

procedure(cadxCheck(S) let((r exp nodeNets netNodes missing got name tname opens shorts gndBad portsOk created refsN names ok e)
  r = schCheck(S["cv"])
  S["errors"] = if(r then car(r) else 0) S["warnings"] = if(r then cadr(r) else 0)
  dbSave(S["cv"])
  exp = S["plan"]["expected"]
  nodeNets = makeTable("nn" nil) netNodes = makeTable("nn2" nil) missing = 0
  foreach(x exp["terminals"]
    got = S["insts"][x["ref"]] name = nil
    when(got
      e = caddr(got)
      tname = if(x["index"] < length(e["terms"]) then nth(x["index"] e["terms"]) else nil)
      foreach(it car(got)->instTerms when(it->name == tname && it->net name = it->net->name)))
    unless(name
      missing = missing + 1
      S["local"] = cons(sprintf(nil "unconnected: %s terminal %d" x["ref"] x["index"]) S["local"])
      name = sprintf(nil "?open:%s:%d" x["ref"] x["index"]))
    unless(member(name nodeNets[x["node"]]) nodeNets[x["node"]] = cons(name nodeNets[x["node"]]))
    unless(member(x["node"] netNodes[name]) netNodes[name] = cons(x["node"] netNodes[name])))
  opens = missing shorts = 0
  foreach(k cadxKeys(nodeNets) when(length(nodeNets[k]) > 1 opens = opens + 1
    S["local"] = cons(sprintf(nil "open: deck node %s on %d nets" k length(nodeNets[k])) S["local"])))
  foreach(k cadxKeys(netNodes) when(length(netNodes[k]) > 1 shorts = shorts + 1
    S["local"] = cons(sprintf(nil "short: %s" k) S["local"])))
  gndBad = 0
  foreach(n exp["ground"] unless(equal(nodeNets[n] list("gnd!")) gndBad = gndBad + 1))
  portsOk = 0
  foreach(p exp["ports"] when(equal(nodeNets[p["node"]] list(p["name"])) portsOk = portsOk + 1))
  refsN = length(S["plan"]["components"]) created = 0
  foreach(i S["cv"]->instances when(S["insts"][i->name] && member(i->name S["refs"]) created = created + 1))
  S["result"] = cadxD(list("instancesExpected" refsN "instancesCreated" created
    "netsExpected" length(cadxKeys(nodeNets)) "netsFound" length(cadxKeys(netNodes))
    "opens" opens "shorts" shorts "groundWrong" gndBad "portsOk" portsOk "portsExpected" length(exp["ports"])
    "overlaps" cadxOverlaps(S)))
  ok = created == refsN && opens == 0 && shorts == 0 && gndBad == 0 && portsOk == length(exp["ports"])
       && S["errors"] == 0 && !S["problems"]
  S["ok"] = ok
  ok))

procedure(cadxOverlaps(S) let((boxes n a b rest)
  foreach(k cadxKeys(S["insts"]) boxes = append1(boxes dbTransformBBox(car(S["insts"][k])->master->bBox car(S["insts"][k])->transform)))
  n = 0
  while(boxes
    a = car(boxes) rest = cdr(boxes)
    foreach(b rest
      when(car(car(a)) < car(cadr(b)) - cadxEps && car(car(b)) < car(cadr(a)) - cadxEps
           && cadr(car(a)) < cadr(cadr(b)) - cadxEps && cadr(car(b)) < cadr(cadr(a)) - cadxEps n = n + 1))
    boxes = rest)
  n))

procedure(cadxReport(S) let((r roles keys txt)
  r = S["result"]
  roles = makeTable("roles" 0)
  foreach(c S["plan"]["components"] roles[c["role"]] = roles[c["role"]] + 1)
  keys = sort(cadxKeys(roles) 'alphalessp)
  txt = strcat(
    sprintf(nil "cadence-export report (schema-neutre/1 -> Virtuoso, SKILL), runtime %s\n" cadxVersion)
    sprintf(nil "plan: %s\n" S["plan"]["id"])
    sprintf(nil "result: %s\n" if(S["ok"] then "PASS" else "FAIL"))
    sprintf(nil "instances: expected %d, created %d\n" r["instancesExpected"] r["instancesCreated"])
    sprintf(nil "nets (deck): %d, found %d\n" r["netsExpected"] r["netsFound"])
    sprintf(nil "opens: %d, shorts: %d, ground wrong: %d\n" r["opens"] r["shorts"] r["groundWrong"])
    sprintf(nil "ports: %d/%d\n" r["portsOk"] r["portsExpected"])
    sprintf(nil "schCheck: errors %d, warnings %d\n" S["errors"] S["warnings"])
    sprintf(nil "wires: segments %d, stubs %d (length %.4g), label fallbacks %d, bulk labels %d, labels %d\n"
      S["segments"] S["stubs"] S["stubLength"] S["fallbacks"] S["bulkLabels"] S["labels"])
    sprintf(nil "params: set %d, skipped %d\n" S["paramsSet"] S["paramsSkipped"])
    sprintf(nil "instance overlaps: %d\n" r["overlaps"]))
  txt = strcat(txt "roles:")
  foreach(k keys txt = strcat(txt sprintf(nil " %s %d" k roles[k]) if(k == car(cadxLast(keys)) then "" else ",")))
  txt = strcat(txt "\n")
  foreach(p sort(S["problems"] 'alphalessp) txt = strcat(txt "problem: " p "\n"))
  txt))

; the real terminal points of each role's symbol (JSON, cadence-profile/1): stays on this machine
procedure(cadxNum(v) sprintf(nil "%g" float(v)))
procedure(cadxPt(p) sprintf(nil "[%s, %s]" cadxNum(car(p)) cadxNum(cadr(p))))
procedure(cadxWriteProfile(S path) let((port roles rs entry first tfirst)
  port = outfile(path)
  unless(port error("profile file not writable"))
  fprintf(port "{\"format\": \"cadence-profile/1\", \"warning\": \"%s\", \"grid\": %s, \"symbols\": {" "LOCAL FILE: pin positions of your symbols (foundry kit under NDA). Never send it." cadxNum(S["g"]))
  roles = sort(cadxKeys(S["profile"]) 'alphalessp)
  first = t
  foreach(r roles
    entry = S["profile"][r]
    fprintf(port "%s\n \"%s\": {\"order\": [" if(first then "" else ",") r)
    tfirst = t
    foreach(n car(entry) fprintf(port "%s\"%s\"" if(tfirst then "" else ", ") n) tfirst = nil)
    fprintf(port "], \"bbox\": [%s, %s], \"terms\": {" cadxPt(car(cadr(entry))) cadxPt(cadr(cadr(entry))))
    tfirst = t
    foreach(n car(entry) when(caddr(entry)[n]
      fprintf(port "%s\"%s\": %s" if(tfirst then "" else ", ") n cadxPt(caddr(entry)[n])) tfirst = nil))
    fprintf(port "}}")
    first = nil)
  fprintf(port "}}\n")
  close(port)
  t))

procedure(cadxExport(lib @key (cell nil) (map nil) (report "cadence-report.txt") (overwrite nil) (detail nil) (writeProfile nil))
  let((m S ok txt port)
    m = makeTable("map" nil) m["@keys"] = nil
    cadxParseMap(cadxDefaultMap m)
    when(map cadxReadMap(map m))
    S = cadxNew(cadxPlan m lib if(cell then cell else cadxPlan["cell"]) overwrite)
    cadxOpen(S) cadxPlace(S) cadxPlanned(S) cadxStubs(S) cadxDraw(S) cadxSymbols(S)
    ok = cadxCheck(S)
    when(writeProfile cadxWriteProfile(S writeProfile))
    txt = cadxReport(S)
    port = outfile(report)
    when(port fprintf(port "%s" txt) close(port))
    printf("%s" txt)
    when(detail && S["local"]
      printf("--- LOCAL DETAIL: do not send ---\n")
      foreach(x reverse(S["local"]) printf("%s\n" x)))
    ok))
