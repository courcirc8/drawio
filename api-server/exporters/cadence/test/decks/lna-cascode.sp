* inductively degenerated cascode LNA
L1 in g1 8n
M1 x g1 s1 0 nmos W=40u L=0.13u
L2 s1 0 1n
M2 out vb x 0 nmos W=40u L=0.13u
L3 vdd out 4n
VDD vdd 0 1.2
.end
