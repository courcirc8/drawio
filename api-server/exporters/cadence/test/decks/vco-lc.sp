* cross-coupled NMOS LC VCO
L1 vdd outp 2n
L2 vdd outm 2n
C1 outp outm 1p
M1 outp outm s 0 nmos W=20u L=0.13u
M2 outm outp s 0 nmos W=20u L=0.13u
I1 s 0 4m
VDD vdd 0 1.2
.end
