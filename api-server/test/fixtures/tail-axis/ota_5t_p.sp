* five-transistor OTA, PMOS pair (witness)
M1 x inp tail vdd pmos W=10u L=0.5u
M2 out inn tail vdd pmos W=10u L=0.5u
M3 x x 0 0 nmos W=5u L=0.5u
M4 out x 0 0 nmos W=5u L=0.5u
M5 tail vbp vdd vdd pmos W=10u L=1u
CL out 0 1p
.end
