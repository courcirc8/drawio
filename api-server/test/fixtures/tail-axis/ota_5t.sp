* five-transistor OTA, NMOS pair (witness)
M1 x inp tail 0 nmos W=10u L=0.5u
M2 out inn tail 0 nmos W=10u L=0.5u
M3 x x vdd vdd pmos W=5u L=0.5u
M4 out x vdd vdd pmos W=5u L=0.5u
M5 tail vbn 0 0 nmos W=10u L=1u
CL out 0 1p
.end
