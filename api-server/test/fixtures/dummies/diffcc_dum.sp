* DIFFCC with XM1 marked dummy=1 (same outcome)
XM1 tail vdd vdd vdd sg13_lv_pmos w=5u l=0.13u m=2 dummy=1
XM2 outa inp tail vdd sg13_lv_pmos w=5u l=0.13u m=4
XM4 outb inm tail vdd sg13_lv_pmos w=5u l=0.13u m=4
.end
