* DIFFCC as layout3d sent it (Layout3D, 08.11): XM1 always off (PMOS gate on vdd), the pair XM2/XM4; vdd left on page 1 only as the pair's bulk
XM1 tail vdd vdd vdd sg13_lv_pmos w=5u l=0.13u m=2
XM2 outa inp tail vdd sg13_lv_pmos w=5u l=0.13u m=4
XM4 outb inm tail vdd sg13_lv_pmos w=5u l=0.13u m=4
.end
