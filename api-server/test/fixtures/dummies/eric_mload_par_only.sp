* MLOAD flat, parasitic estimates only (no dummy)
XM3 d3 d3 vss vss sg13_hv_nmos w=35u l=8u ng=8
XM4 o1 d3 vss vss sg13_hv_nmos w=35u l=8u ng=8
Cp1 d3 vss 12.5f lvs_ignore=1
Cp2 o1 vss 8.1f lvs_ignore=1
.end
