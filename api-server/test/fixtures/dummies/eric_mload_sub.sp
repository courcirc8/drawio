* MLOAD exact (Eric 08.11)
.subckt MLOAD d3 o1 vss
XM3 d3 d3 vss vss sg13_hv_nmos w=35u l=8u ng=8
XM4 o1 d3 vss vss sg13_hv_nmos w=35u l=8u ng=8
.ends
.end
