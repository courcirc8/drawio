* DIFFCC with its supply named vp: a supply by its devices only (bulk of the pair's PMOS), never by its name.
* Review #81 pass 2: no global supply then; page 1 does not name it (bulks only) and it is no pin: a 422 (c).
XM1 tail vp vp vp sg13_lv_pmos w=5u l=0.13u m=2 dummy=1
XM2 outa inp tail vp sg13_lv_pmos w=5u l=0.13u m=4
XM4 outb inm tail vp sg13_lv_pmos w=5u l=0.13u m=4
.end
