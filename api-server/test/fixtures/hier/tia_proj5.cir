* TIA Butterworth 3, cycle 5 (analog-design session, IHP SG13G2 open PDK), generated by tia-butterworth3/proj5/bloc.py circuit(DEFAUT) 2026-10-25 for drawio hier tests
* chaine TIA-Butterworth3, code 0 (20 MHz)
.lib cornerMOSlv.lib mos_tt
.lib cornerRES.lib res_typ
.lib cornerCAP.lib cap_typ
.temp 27
VDD vdd 0 1.2
VOCM vcmref 0 0.75
VOCM1 vcmref1 0 0.75
.lib cornerHBT.lib hbt_typ
.subckt ota1 inp inn outp outn vdd vcmref
* OTA FD a etage d'entree cascode (lv)
IB vdd vbn 0.00024000000000000003
XM0 vbn vbn 0 0 sg13_lv_nmos w=36u l=4u ng=8 m=1
XM5 tail vbn 0 0 sg13_lv_nmos w=49.622u l=4u ng=10 m=37
XM1 d1a inp tail 0 sg13_lv_nmos w=50u l=0.13u ng=10 m=312
XM2 d1b inn tail 0 sg13_lv_nmos w=50u l=0.13u ng=10 m=312
XMCA o1a vcn d1a 0 sg13_lv_nmos w=48.75u l=0.13u ng=10 m=32
XMCB o1b vcn d1b 0 sg13_lv_nmos w=48.75u l=0.13u ng=10 m=32
XMPA o1a vcp p1a vdd sg13_lv_pmos w=50u l=0.13u ng=10 m=48
XMPB o1b vcp p1b vdd sg13_lv_pmos w=50u l=0.13u ng=10 m=48
XM3 p1a vcmfb vdd vdd sg13_lv_pmos w=50u l=1u ng=10 m=80
XM4 p1b vcmfb vdd vdd sg13_lv_pmos w=50u l=1u ng=10 m=80
XM6A outp o1a vdd vdd sg13_lv_pmos w=50u l=0.13u ng=10 m=60
XM6B outn o1b vdd vdd sg13_lv_pmos w=50u l=0.13u ng=10 m=60
XM7A outp vbn 0 0 sg13_lv_nmos w=50u l=4u ng=10 m=9
XM7B outn vbn 0 0 sg13_lv_nmos w=50u l=4u ng=10 m=9
XCCA o1a za cap_cmim w=44.67u l=44.67u
XRZA za outp 0 rppd w=0.5u l=0.6033u b=0 m=3
XCCB o1b zb cap_cmim w=44.67u l=44.67u
XRZB zb outn 0 rppd w=0.5u l=0.6033u b=0 m=3
* polarisation des cascodes (répliques)
XMQ1 vpd vbn 0 0 sg13_lv_nmos w=36u l=4u ng=8 m=1
XMPD vpd vpd vdd vdd sg13_lv_pmos w=47u l=0.5u ng=10 m=12
XMPN vcn vpd vdd vdd sg13_lv_pmos w=47u l=0.5u ng=10 m=12
XMBN vcn vcn xbn 0 sg13_lv_nmos w=31.2u l=0.13u ng=10 m=2
XRBN xbn tail 0 rppd w=0.5u l=0.96u b=0 m=1
XRBP vdd ybp 0 rppd w=0.5u l=1.187u b=0 m=1
XMBP vcp vcp ybp vdd sg13_lv_pmos w=48u l=0.13u ng=10 m=2
XMQ2 vcp vbn 0 0 sg13_lv_nmos w=36u l=4u ng=8 m=1
* CMFB
RCMA outp vcms 200000.0
RCMB outn vcms 200000.0
CCMA outp vcms 2e-13
CCMB outn vcms 2e-13
XM10 tcm vbn 0 0 sg13_lv_nmos w=45u l=4u ng=10 m=4
XM8 vcmfb vcms tcm 0 sg13_lv_nmos w=48u l=0.5u ng=10 m=17
XM9 dcm vcmref tcm 0 sg13_lv_nmos w=48u l=0.5u ng=10 m=17
XM11 vcmfb vcmfb vdd vdd sg13_lv_pmos w=50u l=1u ng=10 m=8
XM12 dcm dcm vdd vdd sg13_lv_pmos w=50u l=1u ng=10 m=8
RPOR vdd por 500000.0
CPOR por 0 2e-11
XKA o1a por vdd vdd sg13_lv_pmos w=1e-05 l=0.13u ng=1 m=1
XKB o1b por vdd vdd sg13_lv_pmos w=1e-05 l=0.13u ng=1 m=1
.ends ota1
.subckt ota2 inp inn outp outn vdd vcmref
* OTA FD a etage d'entree cascode (lv)
IB vdd vbn 1.2e-05
XM0 vbn vbn 0 0 sg13_lv_nmos w=2.7u l=0.5u ng=1 m=1
XM5 tail vbn 0 0 sg13_lv_nmos w=45.9u l=0.5u ng=10 m=3
XM1 d1a inp tail 0 sg13_lv_nmos w=50u l=0.13u ng=10 m=6
XM2 d1b inn tail 0 sg13_lv_nmos w=50u l=0.13u ng=10 m=6
XMCA o1a vcn d1a 0 sg13_lv_nmos w=39u l=0.13u ng=10 m=2
XMCB o1b vcn d1b 0 sg13_lv_nmos w=39u l=0.13u ng=10 m=2
XMPA o1a vcp p1a vdd sg13_lv_pmos w=40u l=0.13u ng=10 m=3
XMPB o1b vcp p1b vdd sg13_lv_pmos w=40u l=0.13u ng=10 m=3
XM3 p1a vcmfb vdd vdd sg13_lv_pmos w=48u l=0.5u ng=10 m=5
XM4 p1b vcmfb vdd vdd sg13_lv_pmos w=48u l=0.5u ng=10 m=5
XM6A outp o1a vdd vdd sg13_lv_pmos w=50u l=0.13u ng=10 m=6
XM6B outn o1b vdd vdd sg13_lv_pmos w=50u l=0.13u ng=10 m=6
XM7A outp vbn 0 0 sg13_lv_nmos w=33.75u l=0.5u ng=10 m=2
XM7B outn vbn 0 0 sg13_lv_nmos w=33.75u l=0.5u ng=10 m=2
XCCA o1a za cap_cmim w=48.94u l=48.94u
XRZA za outp 0 rppd w=0.5u l=0.798u b=0 m=3
XCCB o1b zb cap_cmim w=48.94u l=48.94u
XRZB zb outn 0 rppd w=0.5u l=0.798u b=0 m=3
* polarisation des cascodes (répliques)
XMQ1 vpd vbn 0 0 sg13_lv_nmos w=2.7u l=0.5u ng=1 m=1
XMPD vpd vpd vdd vdd sg13_lv_pmos w=28.2u l=0.5u ng=6 m=1
XMPN vcn vpd vdd vdd sg13_lv_pmos w=28.2u l=0.5u ng=6 m=1
XMBN vcn vcn xbn 0 sg13_lv_nmos w=3.12u l=0.13u ng=1 m=1
XRBN xbn tail 0 rppd w=0.5u l=24.06u b=0 m=1
XRBP vdd ybp 0 rppd w=0.5u l=28.92u b=0 m=1
XMBP vcp vcp ybp vdd sg13_lv_pmos w=4.8u l=0.13u ng=1 m=1
XMQ2 vcp vbn 0 0 sg13_lv_nmos w=2.7u l=0.5u ng=1 m=1
* CMFB
RCMA outp vcms 200000.0
RCMB outn vcms 200000.0
CCMA outp vcms 2e-13
CCMB outn vcms 2e-13
XM10 tcm vbn 0 0 sg13_lv_nmos w=13.5u l=0.5u ng=3 m=1
XM8 vcmfb vcms tcm 0 sg13_lv_nmos w=40.8u l=0.5u ng=9 m=1
XM9 dcm vcmref tcm 0 sg13_lv_nmos w=40.8u l=0.5u ng=9 m=1
XM11 vcmfb vcmfb vdd vdd sg13_lv_pmos w=24u l=0.5u ng=5 m=1
XM12 dcm dcm vdd vdd sg13_lv_pmos w=24u l=0.5u ng=5 m=1
.ends ota2
.subckt ota3 inp inn outp outn vdd vcmref
* OTA FD a etage d'entree cascode (lv)
IB vdd vbn 1.2e-05
XM0 vbn vbn 0 0 sg13_lv_nmos w=2.7u l=0.5u ng=1 m=1
XM5 tail vbn 0 0 sg13_lv_nmos w=45.9u l=0.5u ng=10 m=3
XM1 d1a inp tail 0 sg13_lv_nmos w=50u l=0.13u ng=10 m=6
XM2 d1b inn tail 0 sg13_lv_nmos w=50u l=0.13u ng=10 m=6
XMCA o1a vcn d1a 0 sg13_lv_nmos w=39u l=0.13u ng=10 m=2
XMCB o1b vcn d1b 0 sg13_lv_nmos w=39u l=0.13u ng=10 m=2
XMPA o1a vcp p1a vdd sg13_lv_pmos w=40u l=0.13u ng=10 m=3
XMPB o1b vcp p1b vdd sg13_lv_pmos w=40u l=0.13u ng=10 m=3
XM3 p1a vcmfb vdd vdd sg13_lv_pmos w=48u l=0.5u ng=10 m=5
XM4 p1b vcmfb vdd vdd sg13_lv_pmos w=48u l=0.5u ng=10 m=5
XM6A outp o1a vdd vdd sg13_lv_pmos w=50u l=0.13u ng=10 m=6
XM6B outn o1b vdd vdd sg13_lv_pmos w=50u l=0.13u ng=10 m=6
XM7A outp vbn 0 0 sg13_lv_nmos w=33.75u l=0.5u ng=10 m=2
XM7B outn vbn 0 0 sg13_lv_nmos w=33.75u l=0.5u ng=10 m=2
XCCA o1a za cap_cmim w=48.94u l=48.94u
XRZA za outp 0 rppd w=0.5u l=0.798u b=0 m=3
XCCB o1b zb cap_cmim w=48.94u l=48.94u
XRZB zb outn 0 rppd w=0.5u l=0.798u b=0 m=3
* polarisation des cascodes (répliques)
XMQ1 vpd vbn 0 0 sg13_lv_nmos w=2.7u l=0.5u ng=1 m=1
XMPD vpd vpd vdd vdd sg13_lv_pmos w=28.2u l=0.5u ng=6 m=1
XMPN vcn vpd vdd vdd sg13_lv_pmos w=28.2u l=0.5u ng=6 m=1
XMBN vcn vcn xbn 0 sg13_lv_nmos w=3.12u l=0.13u ng=1 m=1
XRBN xbn tail 0 rppd w=0.5u l=24.06u b=0 m=1
XRBP vdd ybp 0 rppd w=0.5u l=28.92u b=0 m=1
XMBP vcp vcp ybp vdd sg13_lv_pmos w=4.8u l=0.13u ng=1 m=1
XMQ2 vcp vbn 0 0 sg13_lv_nmos w=2.7u l=0.5u ng=1 m=1
* CMFB
RCMA outp vcms 200000.0
RCMB outn vcms 200000.0
CCMA outp vcms 2e-13
CCMB outn vcms 2e-13
XM10 tcm vbn 0 0 sg13_lv_nmos w=13.5u l=0.5u ng=3 m=1
XM8 vcmfb vcms tcm 0 sg13_lv_nmos w=40.8u l=0.5u ng=9 m=1
XM9 dcm vcmref tcm 0 sg13_lv_nmos w=40.8u l=0.5u ng=9 m=1
XM11 vcmfb vcmfb vdd vdd sg13_lv_pmos w=24u l=0.5u ng=5 m=1
XM12 dcm dcm vdd vdd sg13_lv_pmos w=24u l=0.5u ng=5 m=1
.ends ota3
IIN inn inp DC 0
RS inp inn 600.0 noisy=0
CPS1 inp 0 5e-12
CPS2 inn 0 5e-12
XA1 inp inn o1p o1n vdd vcmref1 ota1
XKP inp o1n vcmref1 vdd sg13_lv_pmos w=2.0u l=0.13u ng=1
XKN inn o1p vcmref1 vdd sg13_lv_pmos w=2.0u l=0.13u ng=1
XRF1u0 o1n RF1_1 0 rppd w=0.5u l=1.674u b=0 m=1
XRF1u1 RF1_1 RF1_2 0 rppd w=0.5u l=1.674u b=0 m=1
XRF1u2 RF1_2 RF1_3 0 rppd w=0.5u l=1.674u b=0 m=1
XRF1u3 RF1_3 RF1_4 0 rppd w=0.5u l=1.674u b=0 m=1
XRF1u4 RF1_4 RF1_5 0 rppd w=0.5u l=1.674u b=0 m=1
XRF1u5 RF1_5 RF1_6 0 rppd w=0.5u l=1.674u b=0 m=1
XRF1u6 RF1_6 RF1_7 0 rppd w=0.5u l=1.674u b=0 m=1
XRF1u7 RF1_7 RF1_8 0 rppd w=0.5u l=1.674u b=0 m=1
XRF1u8 RF1_8 RF1_9 0 rppd w=0.5u l=1.674u b=0 m=1
XRF1u9 RF1_9 RF1_10 0 rppd w=0.5u l=1.674u b=0 m=1
XRF1u10 RF1_10 RF1_11 0 rppd w=0.5u l=1.674u b=0 m=1
XRF1u11 RF1_11 RF1_12 0 rppd w=0.5u l=1.674u b=0 m=1
XRF1u12 RF1_12 RF1_13 0 rppd w=0.5u l=1.674u b=0 m=1
XRF1u13 RF1_13 RF1_14 0 rppd w=0.5u l=1.674u b=0 m=1
XRF1u14 RF1_14 RF1_15 0 rppd w=0.5u l=1.674u b=0 m=1
XRF1u15 RF1_15 RF1_16 0 rppd w=0.5u l=1.674u b=0 m=1
XRF1u16 RF1_16 RF1_17 0 rppd w=0.5u l=1.674u b=0 m=1
XRF1u17 RF1_17 RF1_18 0 rppd w=0.5u l=1.674u b=0 m=1
XRF1u18 RF1_18 RF1_19 0 rppd w=0.5u l=1.674u b=0 m=1
XRF1u19 RF1_19 RF1_20 0 rppd w=0.5u l=1.674u b=0 m=1
XRF1u20 RF1_20 RF1_21 0 rppd w=0.5u l=1.674u b=0 m=1
XRF1u21 RF1_21 RF1_22 0 rppd w=0.5u l=1.674u b=0 m=1
XRF1u22 RF1_22 inp 0 rppd w=0.5u l=1.674u b=0 m=1
XRF2u0 o1p RF2_1 0 rppd w=0.5u l=1.674u b=0 m=1
XRF2u1 RF2_1 RF2_2 0 rppd w=0.5u l=1.674u b=0 m=1
XRF2u2 RF2_2 RF2_3 0 rppd w=0.5u l=1.674u b=0 m=1
XRF2u3 RF2_3 RF2_4 0 rppd w=0.5u l=1.674u b=0 m=1
XRF2u4 RF2_4 RF2_5 0 rppd w=0.5u l=1.674u b=0 m=1
XRF2u5 RF2_5 RF2_6 0 rppd w=0.5u l=1.674u b=0 m=1
XRF2u6 RF2_6 RF2_7 0 rppd w=0.5u l=1.674u b=0 m=1
XRF2u7 RF2_7 RF2_8 0 rppd w=0.5u l=1.674u b=0 m=1
XRF2u8 RF2_8 RF2_9 0 rppd w=0.5u l=1.674u b=0 m=1
XRF2u9 RF2_9 RF2_10 0 rppd w=0.5u l=1.674u b=0 m=1
XRF2u10 RF2_10 RF2_11 0 rppd w=0.5u l=1.674u b=0 m=1
XRF2u11 RF2_11 RF2_12 0 rppd w=0.5u l=1.674u b=0 m=1
XRF2u12 RF2_12 RF2_13 0 rppd w=0.5u l=1.674u b=0 m=1
XRF2u13 RF2_13 RF2_14 0 rppd w=0.5u l=1.674u b=0 m=1
XRF2u14 RF2_14 RF2_15 0 rppd w=0.5u l=1.674u b=0 m=1
XRF2u15 RF2_15 RF2_16 0 rppd w=0.5u l=1.674u b=0 m=1
XRF2u16 RF2_16 RF2_17 0 rppd w=0.5u l=1.674u b=0 m=1
XRF2u17 RF2_17 RF2_18 0 rppd w=0.5u l=1.674u b=0 m=1
XRF2u18 RF2_18 RF2_19 0 rppd w=0.5u l=1.674u b=0 m=1
XRF2u19 RF2_19 RF2_20 0 rppd w=0.5u l=1.674u b=0 m=1
XRF2u20 RF2_20 RF2_21 0 rppd w=0.5u l=1.674u b=0 m=1
XRF2u21 RF2_21 RF2_22 0 rppd w=0.5u l=1.674u b=0 m=1
XRF2u22 RF2_22 inn 0 rppd w=0.5u l=1.674u b=0 m=1
XF10 o1n inp cap_cmim w=15.88u l=15.88u
XF1c1 o1n F1s1 cap_cmim w=9.888u l=9.888u
XSWF11 inp gF11 F1s1 vdd sg13_lv_pmos w=2u l=0.13u ng=1 m=1
VGF11 gF11 0 1.2
RKF11 F1s1 vcmref1 1G
XF1c2 o1n F1s2 cap_cmim w=11.67u l=11.67u
XSWF12 inp gF12 F1s2 vdd sg13_lv_pmos w=2u l=0.13u ng=1 m=1
VGF12 gF12 0 1.2
RKF12 F1s2 vcmref1 1G
XF1c3 o1n F1s3 cap_cmim w=13.76u l=13.76u
XSWF13 inp gF13 F1s3 vdd sg13_lv_pmos w=2u l=0.13u ng=1 m=1
VGF13 gF13 0 1.2
RKF13 F1s3 vcmref1 1G
XF1c4 o1n F1s4 cap_cmim w=16.23u l=16.23u
XSWF14 inp gF14 F1s4 vdd sg13_lv_pmos w=2.386u l=0.13u ng=1 m=1
VGF14 gF14 0 1.2
RKF14 F1s4 vcmref1 1G
XF1c5 o1n F1s5 cap_cmim w=19.14u l=19.14u
XSWF15 inp gF15 F1s5 vdd sg13_lv_pmos w=3.315u l=0.13u ng=1 m=1
VGF15 gF15 0 1.2
RKF15 F1s5 vcmref1 1G
XF1c6 o1n F1s6 cap_cmim w=22.57u l=22.57u
XSWF16 inp gF16 F1s6 vdd sg13_lv_pmos w=4.607u l=0.13u ng=1 m=1
VGF16 gF16 0 1.2
RKF16 F1s6 vcmref1 1G
XF1c7 o1n F1s7 cap_cmim w=26.62u l=26.62u
XSWF17 inp gF17 F1s7 vdd sg13_lv_pmos w=6.401u l=0.13u ng=2 m=1
VGF17 gF17 0 1.2
RKF17 F1s7 vcmref1 1G
XF20 o1p inn cap_cmim w=15.88u l=15.88u
XF2c1 o1p F2s1 cap_cmim w=9.888u l=9.888u
XSWF21 inn gF21 F2s1 vdd sg13_lv_pmos w=2u l=0.13u ng=1 m=1
VGF21 gF21 0 1.2
RKF21 F2s1 vcmref1 1G
XF2c2 o1p F2s2 cap_cmim w=11.67u l=11.67u
XSWF22 inn gF22 F2s2 vdd sg13_lv_pmos w=2u l=0.13u ng=1 m=1
VGF22 gF22 0 1.2
RKF22 F2s2 vcmref1 1G
XF2c3 o1p F2s3 cap_cmim w=13.76u l=13.76u
XSWF23 inn gF23 F2s3 vdd sg13_lv_pmos w=2u l=0.13u ng=1 m=1
VGF23 gF23 0 1.2
RKF23 F2s3 vcmref1 1G
XF2c4 o1p F2s4 cap_cmim w=16.23u l=16.23u
XSWF24 inn gF24 F2s4 vdd sg13_lv_pmos w=2.386u l=0.13u ng=1 m=1
VGF24 gF24 0 1.2
RKF24 F2s4 vcmref1 1G
XF2c5 o1p F2s5 cap_cmim w=19.14u l=19.14u
XSWF25 inn gF25 F2s5 vdd sg13_lv_pmos w=3.315u l=0.13u ng=1 m=1
VGF25 gF25 0 1.2
RKF25 F2s5 vcmref1 1G
XF2c6 o1p F2s6 cap_cmim w=22.57u l=22.57u
XSWF26 inn gF26 F2s6 vdd sg13_lv_pmos w=4.607u l=0.13u ng=1 m=1
VGF26 gF26 0 1.2
RKF26 F2s6 vcmref1 1G
XF2c7 o1p F2s7 cap_cmim w=26.62u l=26.62u
XSWF27 inn gF27 F2s7 vdd sg13_lv_pmos w=6.401u l=0.13u ng=2 m=1
VGF27 gF27 0 1.2
RKF27 F2s7 vcmref1 1G
XA2 y2p y2n o2p o2n vdd vcmref ota2
XA3 y3p y3n o3p o3n vdd vcmref ota3
XRI1u0 o1p RI1_1 0 rppd w=0.5u l=1.674u b=0 m=1
XRI1u1 RI1_1 y2p 0 rppd w=0.5u l=1.674u b=0 m=1
XRI2u0 o1n RI2_1 0 rppd w=0.5u l=1.674u b=0 m=1
XRI2u1 RI2_1 y2n 0 rppd w=0.5u l=1.674u b=0 m=1
XRQ1u0 o2n y2p 0 rppd w=0.5u l=1.674u b=0 m=1
XRQ2u0 o2p y2n 0 rppd w=0.5u l=1.674u b=0 m=1
XC10 o2n y2p cap_cmim w=76.34u l=76.34u
XC1c1 o2n C1s1 cap_cmim w=47.62u l=47.62u
XSWC11 y2p gC11 C1s1 vdd sg13_lv_pmos w=20.46u l=0.13u ng=5 m=1
VGC11 gC11 0 1.2
RKC11 C1s1 vcmref 1G
XC1c2 o2n C1s2 cap_cmim w=56.15u l=56.15u
XSWC12 y2p gC12 C1s2 vdd sg13_lv_pmos w=28.42u l=0.13u ng=6 m=1
VGC12 gC12 0 1.2
RKC12 C1s2 vcmref 1G
XC1c3 o2n C1s3 cap_cmim w=66.19u l=66.19u
XSWC13 y2p gC13 C1s3 vdd sg13_lv_pmos w=39.5u l=0.13u ng=8 m=1
VGC13 gC13 0 1.2
RKC13 C1s3 vcmref 1G
XC1c4 o2n C1s4 cap_cmim w=78.03u l=78.03u
XSWC14 y2p gC14 C1s4 vdd sg13_lv_pmos w=54.88u l=0.13u ng=11 m=1
VGC14 gC14 0 1.2
RKC14 C1s4 vcmref 1G
XC1c5 o2n C1s5 cap_cmim w=91.99u l=91.99u
XSWC15 y2p gC15 C1s5 vdd sg13_lv_pmos w=76.25u l=0.13u ng=16 m=1
VGC15 gC15 0 1.2
RKC15 C1s5 vcmref 1G
XC1c6 o2n C1s6 cap_cmim w=108.4u l=108.4u
XSWC16 y2p gC16 C1s6 vdd sg13_lv_pmos w=106u l=0.13u ng=22 m=1
VGC16 gC16 0 1.2
RKC16 C1s6 vcmref 1G
XC1c7 o2n C1s7 cap_cmim w=127.8u l=127.8u
XSWC17 y2p gC17 C1s7 vdd sg13_lv_pmos w=147.2u l=0.13u ng=30 m=1
VGC17 gC17 0 1.2
RKC17 C1s7 vcmref 1G
XC20 o2p y2n cap_cmim w=76.34u l=76.34u
XC2c1 o2p C2s1 cap_cmim w=47.62u l=47.62u
XSWC21 y2n gC21 C2s1 vdd sg13_lv_pmos w=20.46u l=0.13u ng=5 m=1
VGC21 gC21 0 1.2
RKC21 C2s1 vcmref 1G
XC2c2 o2p C2s2 cap_cmim w=56.15u l=56.15u
XSWC22 y2n gC22 C2s2 vdd sg13_lv_pmos w=28.42u l=0.13u ng=6 m=1
VGC22 gC22 0 1.2
RKC22 C2s2 vcmref 1G
XC2c3 o2p C2s3 cap_cmim w=66.19u l=66.19u
XSWC23 y2n gC23 C2s3 vdd sg13_lv_pmos w=39.5u l=0.13u ng=8 m=1
VGC23 gC23 0 1.2
RKC23 C2s3 vcmref 1G
XC2c4 o2p C2s4 cap_cmim w=78.03u l=78.03u
XSWC24 y2n gC24 C2s4 vdd sg13_lv_pmos w=54.88u l=0.13u ng=11 m=1
VGC24 gC24 0 1.2
RKC24 C2s4 vcmref 1G
XC2c5 o2p C2s5 cap_cmim w=91.99u l=91.99u
XSWC25 y2n gC25 C2s5 vdd sg13_lv_pmos w=76.25u l=0.13u ng=16 m=1
VGC25 gC25 0 1.2
RKC25 C2s5 vcmref 1G
XC2c6 o2p C2s6 cap_cmim w=108.4u l=108.4u
XSWC26 y2n gC26 C2s6 vdd sg13_lv_pmos w=106u l=0.13u ng=22 m=1
VGC26 gC26 0 1.2
RKC26 C2s6 vcmref 1G
XC2c7 o2p C2s7 cap_cmim w=127.8u l=127.8u
XSWC27 y2n gC27 C2s7 vdd sg13_lv_pmos w=147.2u l=0.13u ng=30 m=1
VGC27 gC27 0 1.2
RKC27 C2s7 vcmref 1G
XRL1u0 o3n y2p 0 rppd w=0.5u l=1.674u b=0 m=1
XRL2u0 o3p y2n 0 rppd w=0.5u l=1.674u b=0 m=1
XR31u0 o2p y3p 0 rppd w=0.5u l=1.674u b=0 m=1
XR32u0 o2n y3n 0 rppd w=0.5u l=1.674u b=0 m=1
XC30 o3n y3p cap_cmim w=76.34u l=76.34u
XC3c1 o3n C3s1 cap_cmim w=47.62u l=47.62u
XSWC31 y3p gC31 C3s1 vdd sg13_lv_pmos w=20.46u l=0.13u ng=5 m=1
VGC31 gC31 0 1.2
RKC31 C3s1 vcmref 1G
XC3c2 o3n C3s2 cap_cmim w=56.15u l=56.15u
XSWC32 y3p gC32 C3s2 vdd sg13_lv_pmos w=28.42u l=0.13u ng=6 m=1
VGC32 gC32 0 1.2
RKC32 C3s2 vcmref 1G
XC3c3 o3n C3s3 cap_cmim w=66.19u l=66.19u
XSWC33 y3p gC33 C3s3 vdd sg13_lv_pmos w=39.5u l=0.13u ng=8 m=1
VGC33 gC33 0 1.2
RKC33 C3s3 vcmref 1G
XC3c4 o3n C3s4 cap_cmim w=78.03u l=78.03u
XSWC34 y3p gC34 C3s4 vdd sg13_lv_pmos w=54.88u l=0.13u ng=11 m=1
VGC34 gC34 0 1.2
RKC34 C3s4 vcmref 1G
XC3c5 o3n C3s5 cap_cmim w=91.99u l=91.99u
XSWC35 y3p gC35 C3s5 vdd sg13_lv_pmos w=76.25u l=0.13u ng=16 m=1
VGC35 gC35 0 1.2
RKC35 C3s5 vcmref 1G
XC3c6 o3n C3s6 cap_cmim w=108.4u l=108.4u
XSWC36 y3p gC36 C3s6 vdd sg13_lv_pmos w=106u l=0.13u ng=22 m=1
VGC36 gC36 0 1.2
RKC36 C3s6 vcmref 1G
XC3c7 o3n C3s7 cap_cmim w=127.8u l=127.8u
XSWC37 y3p gC37 C3s7 vdd sg13_lv_pmos w=147.2u l=0.13u ng=30 m=1
VGC37 gC37 0 1.2
RKC37 C3s7 vcmref 1G
XC40 o3p y3n cap_cmim w=76.34u l=76.34u
XC4c1 o3p C4s1 cap_cmim w=47.62u l=47.62u
XSWC41 y3n gC41 C4s1 vdd sg13_lv_pmos w=20.46u l=0.13u ng=5 m=1
VGC41 gC41 0 1.2
RKC41 C4s1 vcmref 1G
XC4c2 o3p C4s2 cap_cmim w=56.15u l=56.15u
XSWC42 y3n gC42 C4s2 vdd sg13_lv_pmos w=28.42u l=0.13u ng=6 m=1
VGC42 gC42 0 1.2
RKC42 C4s2 vcmref 1G
XC4c3 o3p C4s3 cap_cmim w=66.19u l=66.19u
XSWC43 y3n gC43 C4s3 vdd sg13_lv_pmos w=39.5u l=0.13u ng=8 m=1
VGC43 gC43 0 1.2
RKC43 C4s3 vcmref 1G
XC4c4 o3p C4s4 cap_cmim w=78.03u l=78.03u
XSWC44 y3n gC44 C4s4 vdd sg13_lv_pmos w=54.88u l=0.13u ng=11 m=1
VGC44 gC44 0 1.2
RKC44 C4s4 vcmref 1G
XC4c5 o3p C4s5 cap_cmim w=91.99u l=91.99u
XSWC45 y3n gC45 C4s5 vdd sg13_lv_pmos w=76.25u l=0.13u ng=16 m=1
VGC45 gC45 0 1.2
RKC45 C4s5 vcmref 1G
XC4c6 o3p C4s6 cap_cmim w=108.4u l=108.4u
XSWC46 y3n gC46 C4s6 vdd sg13_lv_pmos w=106u l=0.13u ng=22 m=1
VGC46 gC46 0 1.2
RKC46 C4s6 vcmref 1G
XC4c7 o3p C4s7 cap_cmim w=127.8u l=127.8u
XSWC47 y3n gC47 C4s7 vdd sg13_lv_pmos w=147.2u l=0.13u ng=30 m=1
VGC47 gC47 0 1.2
RKC47 C4s7 vcmref 1G
.nodeset v(inp)=0.75 v(inn)=0.75 v(o1p)=0.75 v(o1n)=0.75 v(y2p)=0.75 v(y2n)=0.75 v(y3p)=0.75 v(y3n)=0.75 v(o2p)=0.75 v(o2n)=0.75 v(o3p)=0.75 v(o3n)=0.8
CLP o3p 0 1p
CLN o3n 0 1p
RLD o3p o3n 20k
