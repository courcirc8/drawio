* two-stage Miller OTA as a layout extraction: one device per finger (IHP SG13G2 open PDK)
XM2_1 out o1 vss vss sg13_hv_nmos w=70u l=1u
XM2_2 vss o1 out vss sg13_hv_nmos w=70u l=1u
XM2_3 out o1 vss vss sg13_hv_nmos w=70u l=1u
XM2_4 vss o1 out vss sg13_hv_nmos w=70u l=1u
XM2_5 out o1 vss vss sg13_hv_nmos w=70u l=1u
XM2_6 vss o1 out vss sg13_hv_nmos w=70u l=1u
XM2_7 out o1 vss vss sg13_hv_nmos w=70u l=1u
XM4 d3 d3 vss vss sg13_hv_nmos w=40u l=8u
XM5 o1 d3 vss vss sg13_hv_nmos w=40u l=8u
XM7_1 d3 inp tail vdd sg13_hv_pmos w=200u l=2u
XM7_2 tail inp d3 vdd sg13_hv_pmos w=200u l=2u
XM7_3 d3 inp tail vdd sg13_hv_pmos w=200u l=2u
XM7_4 tail inp d3 vdd sg13_hv_pmos w=200u l=2u
XM8_1 o1 inn tail vdd sg13_hv_pmos w=200u l=2u
XM8_2 tail inn o1 vdd sg13_hv_pmos w=200u l=2u
XM8_3 o1 inn tail vdd sg13_hv_pmos w=200u l=2u
XM8_4 tail inn o1 vdd sg13_hv_pmos w=200u l=2u
XM9_1 out vbp vdd vdd sg13_hv_pmos w=14u l=2u
XM9_2 vdd vbp out vdd sg13_hv_pmos w=14u l=2u
XM10_1 tail vbp vdd vdd sg13_hv_pmos w=5u l=2u
XM10_2 vdd vbp tail vdd sg13_hv_pmos w=5u l=2u
XM10_3 tail vbp vdd vdd sg13_hv_pmos w=5u l=2u
XM10_4 vdd vbp tail vdd sg13_hv_pmos w=5u l=2u
XM10_5 tail vbp vdd vdd sg13_hv_pmos w=5u l=2u
XM11 vbp vbp vdd vdd sg13_hv_pmos w=2u l=2u
XR12 z out rhigh w=0.5u l=22.53u
XC13 o1 z cap_cmim w=32.19u l=32.19u
.end
