CA0 ina inb 0.996p
CAc1 ina As1 0.387p
MSWA1 inb gA1 As1 vdd pmos W=2.337u L=0.13u
RKA1 As1 vg 1G
CAc2 ina As2 0.538p
MSWA2 inb gA2 As2 vdd pmos W=3.247u L=0.13u
RKA2 As2 vg 1G
CAc3 ina As3 0.749p
MSWA3 inb gA3 As3 vdd pmos W=4.512u L=0.13u
RKA3 As3 vg 1G
CAc4 ina As4 1.04p
MSWA4 inb gA4 As4 vdd pmos W=12.538u L=0.13u
RKA4 As4 vg 1G
CAc5 ina As5 1.45p
MSWA5 inb gA5 As5 vdd pmos W=17.422u L=0.13u
RKA5 As5 vg 1G
CAc6 ina As6 2.01p
MSWA6 inb gA6 As6 vdd pmos W=36.3u L=0.13u
RKA6 As6 vg 1G
CAc7 ina As7 2.8p
MSWA7 inb gA7 As7 vdd pmos W=67.28u L=0.13u
RKA7 As7 vg 1G
.end
