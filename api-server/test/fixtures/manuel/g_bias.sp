IB vdd vbn dc 0.0001
M0 vbn vbn 0 0 nmos W=80u L=0.5u
M5 tail vbn 0 0 nmos W=9600u L=0.5u
RBN1 vdd vcn 100000.0
RBN2 vcn 0 500000.0
RBP1 vdd vcp 650000.0
RBP2 vcp 0 550000.0
M7A outp vbn 0 0 nmos W=1600u L=0.5u
M7B outn vbn 0 0 nmos W=1600u L=0.5u
.end
