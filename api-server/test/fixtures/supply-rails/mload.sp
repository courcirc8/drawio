* schema layout3d
XM2 d3 d3 vss vss sg13_hv_nmos w=4.375u l=8u m=8
XM4 o1 d3 vss vss sg13_hv_nmos w=4.375u l=8u m=8
.end
