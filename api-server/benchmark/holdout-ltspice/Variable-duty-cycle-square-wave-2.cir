* Variable-duty-cycle-square-wave-2 — converted from LTspice .asc by tools/asc2spice.mjs
R1 n1 n2 1k
R2 n2 0 10k
C1 n3 0 100n
Q1 n3 n2 n4 PNP_BC640
R3 n1 n4 10k
V1 n1 0 9
Q2 n5 n6 0 BC337-40
Q3 n6 n5 n3 PNP_BC640
R4 n1 n5 10k
R5 n5 0 10k
X_U1 n3 n7 n8 opamp
R6 n1 n7 10k
R7 n7 0 2k
R8 n8 0 ?
.end
