* Worst-Case-Scenario-Simulation-LTSpice — converted from LTspice .asc by tools/asc2spice.mjs
V1 n1 0 ""
C1 n2 n1 {wc_a(10u, tolb)}
R1 n2 Vout {wc_a(10k, tola)}
R2 Vout 0 {wc_a(10k, tola)}
C2 Vout 0 {wc_a(1u, tolb)}
.end
