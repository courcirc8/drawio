* Full-bridge-rectifier — converted from LTspice .asc by tools/asc2spice.mjs
V1 n1 n2 SINE(0 4.86 88)
D2 n1 OUT 1N4148
D3 0 n1 1N4148
D4 n2 OUT 1N4148
D5 0 n2 1N4148
R2 OUT 0 250
C1 OUT 0 600us
.end
