* Comparator-with-hysteresis-window-shifted-from-origin — converted from LTspice .asc by tools/asc2spice.mjs
V1 Vin 0 SINE(0 10 1)
X_U1 n1 Vin Vcc 0 n2 lt1018
V3 Vcc 0 10
Rx n1 Vcc 10k
Ry n1 0 13.3k
Rh n2 n1 13.3k
.end
