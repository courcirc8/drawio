* Three-phase-rectifier — converted from LTspice .asc by tools/asc2spice.mjs
V1 0 n1 SINE(0 -141 50 0 0 0)
V2 0 n2 SINE(0 -141 50 0 0 120)
V3 0 n3 SINE(0 -141 50 0 0 240)
D1 n1 n4 D
D2 n5 n3 D
D3 n2 n4 D
D4 n5 n1 D
D5 n3 n4 D
D6 n5 n2 D
I1 n4 n5 200
.end
