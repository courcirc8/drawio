* RL-highpass — converted from LTspice .asc by tools/asc2spice.mjs
Vin n1 0 SINE(1 1 25000)
L1 0 OUT 100u
R1 n1 OUT 1
.end
