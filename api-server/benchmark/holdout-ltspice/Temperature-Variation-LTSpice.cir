* Temperature-Variation-LTSpice — converted from LTspice .asc by tools/asc2spice.mjs
V1 n1 0 12
R1 n2 0 10k
D1 n2 n1 BZX84C6V2L
.end
