* professional-input-stage — converted from LTspice .asc by tools/asc2spice.mjs
R1 n1 n2 Fuse
D1 n1 n3 D
D2 n4 n3 D
R2 n1 n4 ?
R3 n1 n5 100
C1 n5 n4 0.1u
L1 n4 n1 ?
L2 0 Vcc ?
C2 Vcc 0 2200u
R4 Vcc 0 ?
D3 n6 Vcc D
D4 n7 Vcc D
D5 0 n6 D
D6 0 n7 D
V_Mains_voltage n2 n4 230V
.end
