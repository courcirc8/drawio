* Current-source-BJT — converted from LTspice .asc by tools/asc2spice.mjs
R1 n1 n2 1k
R2 n2 0 10k
R3 n3 0 50k
R4 n1 n4 10k
V1 n1 0 9
Q1 n3 n2 n4 PNP_2N3906
.end
