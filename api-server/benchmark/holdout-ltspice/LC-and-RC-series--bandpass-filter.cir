* LC-and-RC-series--bandpass-filter — converted from LTspice .asc by tools/asc2spice.mjs
L1 n1 n2 25.3u
C1 n1 0 10u
C2 n3 n2 1.591u
R1 n3 0 1k
V1 n2 0 ""
L2 n4 n2 25.3u
C3 n4 0 10u
C4 n5 n4 1.591u
R2 n5 0 1k
.end
