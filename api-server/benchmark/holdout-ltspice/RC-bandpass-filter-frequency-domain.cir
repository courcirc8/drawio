* RC-bandpass-filter-frequency-domain — converted from LTspice .asc by tools/asc2spice.mjs
V1 n1 0 SINE(1 1 25000)
R1 OUT n2 1
C1 OUT 0 100u
C2 n2 n1 100u
R2 n2 0 1
.end
