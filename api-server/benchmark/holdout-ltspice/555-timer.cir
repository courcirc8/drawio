* 555-timer — converted from LTspice .asc by tools/asc2spice.mjs
X_U1 0 n1 n2 power n3 n1 Disc power ne555
R1 power Disc 10k
R2 Disc n1 10k
C1 n1 0 1u
V1 power 0 5
.end
