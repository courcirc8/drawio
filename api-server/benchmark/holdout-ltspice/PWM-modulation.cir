* PWM-modulation — converted from LTspice .asc by tools/asc2spice.mjs
V1 n1 0 PULSE(-1 1 0 5u 5u 0 10u)
V2 n2 0 SINE(0 1 1k)
X_U1 n1 n2 Vcc Vee n3 lt1720
V3 Vcc 0 5
V4 Vee 0 -5
L1 n4 n5 25.3u
C1 n4 0 10u
C2 n6 n4 1.591u
R2 n6 0 1k
R1 n3 n5 1k
R3 n5 0 20k
.end
