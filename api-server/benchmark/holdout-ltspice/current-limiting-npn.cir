* current-limiting-npn — converted from LTspice .asc by tools/asc2spice.mjs
R1 n1 Vcc 54k
R2 0 n2 30
Q1 n3 n1 n2 2N3904
Q2 n1 n2 0 2N3904
V1 Vcc 0 12
R3 Vcc n3 {R_load}
.end
