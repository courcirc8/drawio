* Cockcroft-walton-multiplier — converted from LTspice .asc by tools/asc2spice.mjs
V1 n1 0 SINE(0 10 50)
D1 0 n2 D
D2 n2 n3 D
C1 n1 n2 1p
C2 0 n3 1p
D3 n3 n4 D
D4 n4 n5 D
C3 n3 n5 1p
D5 n5 n6 D
D6 n6 n7 D
C4 n5 n7 1p
C5 n2 n4 1p
C6 n4 n6 1p
.end
