* PNP-transistor-biasing — converted from LTspice .asc by tools/asc2spice.mjs
Q1 n1 n2 n3 PNP_2N2907
R1 n1 0 1
R3 n2 0 11.2k
V1 n3 0 12
.end
