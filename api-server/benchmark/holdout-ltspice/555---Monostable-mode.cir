* 555---Monostable-mode — converted from LTspice .asc by tools/asc2spice.mjs
X_A1 n1 n2 n3 n4 n5 Digital\srflop
R1 Vcc n6 5k
R2 n6 n7 5k
R3 n7 0 5k
R4 Vcc n8 10k
R5 Vcc n9 10k
C1 n9 0 100n
X_U1 n9 n6 Vcc 0 n2 Comparators\LT1018
X_U2 n7 n8 Vcc 0 n1 Comparators\LT1018
V1 Vcc 0 5
Q1 n9 n3 0 NPN
E1 n10 0 n4 0 5
S1 0 n8 n11 0 ?
V2 n11 0 PULSE(0 5 0.2m 1n 1n 10u 100u 1)
.end
