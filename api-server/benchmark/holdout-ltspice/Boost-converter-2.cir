* Boost-converter-2 — converted from LTspice .asc by tools/asc2spice.mjs
V1 n1 0 380
D1 n2 n3 D
L1 n1 n2 10m
C1 n3 0 10u
R1 n3 0 100
S1 0 n2 n4 n5 MOSFET
V2 n4 n5 PULSE(0 100 0 1n 1n 0.052m 0.0625m 1Meg)
.end
