* soft-starter-12V — converted from LTspice .asc by tools/asc2spice.mjs
R1 Vcc Vcap 100k
R2 Vcap 0 100k
C1 Vcap 0 10u
M1 n1 Vcap 0 0 IRF2805
L1 Vcc n2 100u
D1 n1 Vcc 1N4148
R_limit Vcc V_load 3.3
V1 Vcc 0 12
S1 V_load Vcc Vcc n1 RELAY
R4 n2 n1 333
C2 V_load 0 1m
R5 V_load 0 100
.end
