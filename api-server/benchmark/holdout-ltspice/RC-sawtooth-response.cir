* RC-sawtooth-response — converted from LTspice .asc by tools/asc2spice.mjs
R1 n1 n2 10
C1 n1 0 10m
V1 n2 0 PULSE(-200 200 0 500m 0.001u 0.001u 500m 10)
.end
