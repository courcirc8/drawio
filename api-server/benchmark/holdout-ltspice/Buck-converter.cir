* Buck-converter — converted from LTspice .asc by tools/asc2spice.mjs
V1 n1 0 100
D1 0 n2 D
L1 n2 n3 1m
C1 n3 0 10u
R1 n3 0 10
S1 n2 n1 n4 n5 MOSFET
V2 n4 n5 PULSE(0 100 0 1n 1n {D/Fs} {1/Fs} 1Meg)
.end
