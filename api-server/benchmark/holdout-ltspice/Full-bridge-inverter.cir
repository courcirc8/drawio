* Full-bridge-inverter — converted from LTspice .asc by tools/asc2spice.mjs
V1 n1 0 380
C1 n1 n2 1m
C2 n2 0 1m
R1 n3 n4 1
L1 n3 n5 10m
S1 n4 n1 Tp 0 ?
D1 n4 n1 D
S2 0 n4 Tm 0 ?
D2 0 n4 D
V3 n6 0 SINE(0 8 160)
X_U1 n6 n7 n8 n9 n10 lt1721
V4 n8 0 10
V5 n9 0 -10
V2 n7 0 PULSE(-10 10 0 0.03124m 0.03124m 0.00002m 0.0625m)
R2 n2 0 1
R3 n1 n2 1
S3 n5 n1 Tm 0 ?
D3 n5 n1 D
S4 0 n5 Tp 0 ?
D4 0 n5 D
.end
