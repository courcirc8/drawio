* Royer-zvs — converted from LTspice .asc by tools/asc2spice.mjs
R1 n1 n2 240
R2 n1 n3 10
R3 n1 n4 240
L1 n3 n5 1u
L2 n6 n3 1u
L3 n3 n3 10m
C1 n6 n5 330n
D1 n2 n6 D
D2 n4 n5 D
M1 n5 n2 0 0 IRFZ44N
M2 n6 n4 0 0 IRFZ44N
V1 n1 0 15
.end
