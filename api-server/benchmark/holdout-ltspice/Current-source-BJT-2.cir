* Current-source-BJT-2 — converted from LTspice .asc by tools/asc2spice.mjs
V1 Vin 0 1
R_Load n1 n2 2
Q1 n2 n3 n4 2N3904
R2 n4 0 1
X_U1 n4 Vin n3 Opamps\opamp
V2 n1 0 5
.end
