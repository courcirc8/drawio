* ASK-modulation — converted from LTspice .asc by tools/asc2spice.mjs
V1 Vcc 0 5
V_Carrier n1 0 SINE(0 1 1k)
R1 n2 n1 1k
Q1 n2 n3 0 2N3904
Vsignal n4 0 PULSE(5 0 5m 1n 1n 5m 10m 5)
V4 Vee 0 -5
R2 n3 n4 1k
R3 0 n5 20k
C1 0 n5 100n
Rx1 n6 Vcc 10k
Ry1 n6 0 222
Rh1 n7 n6 2.5k
X_U4 n6 n5 Vcc 0 n7 Comparators\LT1720
X_U3 n8 n7 Vcc 0 Vreceived Comparators\LT1720
R4 n8 Vcc 10k
R5 0 n8 2k
R6 Vreceived 0 1k
X_U5 n2 Vant Vcc Vee Vant Opamps\UniversalOpamp2
D1 Vant n5 1N5818
.end
