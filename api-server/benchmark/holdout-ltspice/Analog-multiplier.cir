* Analog-multiplier — converted from LTspice .asc by tools/asc2spice.mjs
X_U1 n1 0 n2 opamp
V1 vin 0 SINE(0.2 0.2 20 0 0 0 10)
R1 n1 vin 500k
D1 n1 n2 1N4148
X_U3 n3 0 n4 opamp
R4 n3 Vin2 500k
R2 n5 n2 5k
R3 n5 n4 5k
R5 0 n6 1k
X_U2 n5 n6 n7 opamp
R6 n7 n5 5k
X_U4 n8 0 n9 opamp
R7 n9 n8 500
R8 n10 n9 1k
X_U5 n10 0 out opamp
R10 out n10 1k
D2 n3 n4 1N4148
D3 n7 n8 1N4148
V2 Vin2 0 SINE(0.3 0.3 1k 0 0 0)
V3 vref 0 1
.end
