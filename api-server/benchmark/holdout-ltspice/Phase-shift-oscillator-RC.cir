* Phase-shift-oscillator-RC — converted from LTspice .asc by tools/asc2spice.mjs
R1 n1 0 65
R2 n2 0 65
R3 n3 0 65
C1 n4 n1 1u
C2 n1 n2 1u
C3 n2 n3 1u
R5 n5 n3 1k
X_U1 0 n5 A B n4 Opamps\LT1002A
R6 n4 n5 32k
V1 A 0 15
V2 B 0 -15
.end
