* Boost-converter-1 — converted from LTspice .asc by tools/asc2spice.mjs
Vd n1 0 100
D1 n2 Vo D
L1 n1 n2 10m
C1 Vo 0 10u
R1 Vo 0 100
S1 0 n2 n3 n4 MOSFET
V2 n3 n4 PULSE(0 100 0 1n 1n {D/Fs} {1/Fs} 1Meg)
.end
