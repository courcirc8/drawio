* Notch-and-band-suppress-filters — converted from LTspice .asc by tools/asc2spice.mjs
L1 n1 n2 331u
C1 n1 n2 7.7n
R1 n1 0 500
Vin n2 0 ""
L2 0 n3 331u
C2 0 n3 7.7n
R2 n3 n2 500
C3 n4 n2 7.7n
L3 n5 n4 331u
R3 0 n5 500
C4 n6 n7 7.7n
L4 0 n6 331u
R4 n7 n2 500
.end
