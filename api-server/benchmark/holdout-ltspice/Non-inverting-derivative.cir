* Non-inverting-derivative — converted from LTspice .asc by tools/asc2spice.mjs
R1 n1 n2 10k
R2 0 n3 10k
C1 n3 n4 100u
C2 n2 0 100u
V1 n4 0 PULSE(0 1 0 100m 100m 1n 200m)
X_U2 n3 n2 Vcc Vee n1 Opamps\LT1007
V2 Vcc 0 10
V3 Vee 0 -10
.end
