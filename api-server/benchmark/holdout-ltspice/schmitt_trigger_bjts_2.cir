* schmitt_trigger_bjts_2 — converted from LTspice .asc by tools/asc2spice.mjs
R1 Vcc Vout 1k
R2 Vout n1 18k
R3 n1 0 910
R4 n1 n2 10k
R5 Vcc n3 1k
R6 n3 n4 18k
Q1 n3 n1 0 2N3904
Q2 Vout n4 0 2N3904
V1 Vcc 0 12
R_Photoresistor1 n5 0 {R}
R_POT1 Vcc n5 8k
E1 n2 0 n5 0 1
.end
