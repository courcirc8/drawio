* Three-phase-naive-inverter — converted from LTspice .asc by tools/asc2spice.mjs
M1 n1 n2 n3 n3 Si7336ADP
M2 n3 n4 n5 n5 Si7336ADP
C1 n1 n6 10u
V1 n1 n6 10
R1 n3 n7 100
L1 n7 0 1m
V2 n2 0 PULSE(0 5 0 1u 1u 0.5 1 10)
V3 n4 0 PULSE(0 5 0.500 1u 1u 0.5 1 10)
M3 n1 n8 n9 n9 Si7336ADP
M4 n9 n10 n5 n5 Si7336ADP
R2 n9 n11 100
L2 n11 0 1m
V4 n8 0 PULSE(0 5 0.3333 1u 1u 0.5 1 10)
V5 n10 0 PULSE(0 5 0.8333 1u 1u 0.5 1 10)
M5 n1 n12 n13 n13 Si7336ADP
M6 n13 n14 n5 n5 Si7336ADP
R3 n13 n15 100
L3 n15 0 1m
V6 n12 0 PULSE(0 5 0.6666 1u 1u 0.5 1 10)
V7 n14 0 PULSE(0 5 1.1666 1u 1u 0.5 1 10)
R4 n5 n6 100
.end
