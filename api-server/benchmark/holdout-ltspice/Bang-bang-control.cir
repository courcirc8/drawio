* Bang-bang-control — converted from LTspice .asc by tools/asc2spice.mjs
X_U1 n1 out Vcc 0 n2 lt1018
V2 Vcc 0 12
Rx1 n1 Vcc 10k
Ry1 n1 0 15k
Rh1 n2 n1 30k
R1 n3 n2 10k
Q1 n4 n3 out 2N3904
R2 Vcc n4 1k
C1 out 0 0.01m
R3 out 0 9k
.end
