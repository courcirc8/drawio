* Single-phase-rectifier-R-load-smoothing-capacitor — converted from LTspice .asc by tools/asc2spice.mjs
V1 n1 n2 SINE(0 4.86 88)
R2 OUT 0 250
C1 OUT 0 100u
D1 n1 OUT D
D2 0 n2 D
D3 n2 OUT D
D4 0 n1 D
.end
