* RLC-step-response-resonance-frequency-series-parallel — converted from LTspice .asc by tools/asc2spice.mjs
V1 n1 0 10
L1 n2 n3 30m
R1 n1 n2 34.64
C1 n3 0 100u
L2 n4 0 30m
R2 n4 0 8.66
C2 n4 0 100u
I1 0 n4 10
V2 n5 0 10
L3 n6 n7 30m
R3 n5 n6 100
C3 n7 0 100u
L4 n8 0 30m
R4 n8 0 8
C4 n8 0 100u
I2 0 n8 10
V3 n9 0 10
L5 n10 n11 30m
R5 n9 n10 5
C5 n11 0 100u
L6 n12 0 30m
R6 n12 0 50
C6 n12 0 100u
I3 0 n12 10
V4 n13 0 SINE(0 1 91.93)
L7 n14 n15 30m
R7 n13 n14 50
C7 n15 0 100u
L8 n16 0 30m
R8 n16 0 8.66
C8 n16 0 100u
I4 0 n16 SINE(0 1 91.93)
.end
