* Greinacher voltage doubler
V1 ac 0 SIN(0 5 1k)
C1 ac x 10u
D1 0 x 1N4148
D2 x out 1N4148
C2 out 0 10u
RL out 0 10k
.end
