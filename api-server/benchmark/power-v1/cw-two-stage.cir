* Cockcroft-Walton multiplier, two stages
V1 ac 0 SIN(0 10 1k)
C1 ac a1 1u
D1 0 a1 D
D2 a1 b1 D
C2 b1 0 1u
C3 a1 a2 1u
D3 b1 a2 D
D4 a2 b2 D
C4 b2 b1 1u
RL b2 0 100k
.end
