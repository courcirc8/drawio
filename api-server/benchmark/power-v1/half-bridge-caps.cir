* half-bridge inverter with split DC link
Vdc pos 0 400
Ca pos mid 1m
Cb mid 0 1m
S1 pos sw gh 0 SW
D1 sw pos D
S2 sw 0 gl 0 SW
D2 0 sw D
Rl sw mid 10
Vgh gh 0 PULSE(0 5 0 1n 1n 10u 20u)
Vgl gl 0 PULSE(5 0 0 1n 1n 10u 20u)
.end
