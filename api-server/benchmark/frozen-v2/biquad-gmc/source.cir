* Biquad Gm-C passe-bas 2e ordre
V1 in 0 AC 1
G1 n1 0 in vout gm1
C1 n1 0 10p
G2 vout 0 n1 vout gm2
C2 vout 0 10p
.end
