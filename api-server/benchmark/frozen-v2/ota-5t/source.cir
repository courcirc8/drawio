* OTA 5 transistors (biblio: ampli/ota, razavi_G_RDec03)
M1 a inp s 0 NMOS
M2 out inm s 0 NMOS
M3 a a vdd vdd PMOS
M4 out a vdd vdd PMOS
M5 s vb 0 0 NMOS
M6 vb vb 0 0 NMOS
I1 vdd vb 20u
.end
